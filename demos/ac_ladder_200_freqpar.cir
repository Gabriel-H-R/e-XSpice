* Benchmark/demo: 200-section RC ladder, dense AC sweep with frequencies
* split across MPI ranks (.OPTIONS ACFREQPAR).
*
*   401 devices, 202 unknowns, 5001 frequencies (DEC 1000/decade, 10 Hz..1 MHz)
*
* One operating point and one linearization, then one complex LU per
* frequency; the frequency loop is the embarrassingly parallel part, so the
* sweep scales with ranks/threads and the CSV stays identical to the serial
* run.
*
* Run:
*   ./build/e-XSpice file demos/ac_ladder_200_freqpar.cir ac.csv
*   mpiexec -n 4 ./build/e-XSpice file demos/ac_ladder_200_freqpar.cir ac.csv

V1 1 0 DC 0 AC 1
R1 1 2 1k
C1 2 0 10n
R2 2 3 1k
C2 3 0 10n
R3 3 4 1k
C3 4 0 10n
R4 4 5 1k
C4 5 0 10n
R5 5 6 1k
C5 6 0 10n
R6 6 7 1k
C6 7 0 10n
R7 7 8 1k
C7 8 0 10n
R8 8 9 1k
C8 9 0 10n
R9 9 10 1k
C9 10 0 10n
R10 10 11 1k
C10 11 0 10n
R11 11 12 1k
C11 12 0 10n
R12 12 13 1k
C12 13 0 10n
R13 13 14 1k
C13 14 0 10n
R14 14 15 1k
C14 15 0 10n
R15 15 16 1k
C15 16 0 10n
R16 16 17 1k
C16 17 0 10n
R17 17 18 1k
C17 18 0 10n
R18 18 19 1k
C18 19 0 10n
R19 19 20 1k
C19 20 0 10n
R20 20 21 1k
C20 21 0 10n
R21 21 22 1k
C21 22 0 10n
R22 22 23 1k
C22 23 0 10n
R23 23 24 1k
C23 24 0 10n
R24 24 25 1k
C24 25 0 10n
R25 25 26 1k
C25 26 0 10n
R26 26 27 1k
C26 27 0 10n
R27 27 28 1k
C27 28 0 10n
R28 28 29 1k
C28 29 0 10n
R29 29 30 1k
C29 30 0 10n
R30 30 31 1k
C30 31 0 10n
R31 31 32 1k
C31 32 0 10n
R32 32 33 1k
C32 33 0 10n
R33 33 34 1k
C33 34 0 10n
R34 34 35 1k
C34 35 0 10n
R35 35 36 1k
C35 36 0 10n
R36 36 37 1k
C36 37 0 10n
R37 37 38 1k
C37 38 0 10n
R38 38 39 1k
C38 39 0 10n
R39 39 40 1k
C39 40 0 10n
R40 40 41 1k
C40 41 0 10n
R41 41 42 1k
C41 42 0 10n
R42 42 43 1k
C42 43 0 10n
R43 43 44 1k
C43 44 0 10n
R44 44 45 1k
C44 45 0 10n
R45 45 46 1k
C45 46 0 10n
R46 46 47 1k
C46 47 0 10n
R47 47 48 1k
C47 48 0 10n
R48 48 49 1k
C48 49 0 10n
R49 49 50 1k
C49 50 0 10n
R50 50 51 1k
C50 51 0 10n
R51 51 52 1k
C51 52 0 10n
R52 52 53 1k
C52 53 0 10n
R53 53 54 1k
C53 54 0 10n
R54 54 55 1k
C54 55 0 10n
R55 55 56 1k
C55 56 0 10n
R56 56 57 1k
C56 57 0 10n
R57 57 58 1k
C57 58 0 10n
R58 58 59 1k
C58 59 0 10n
R59 59 60 1k
C59 60 0 10n
R60 60 61 1k
C60 61 0 10n
R61 61 62 1k
C61 62 0 10n
R62 62 63 1k
C62 63 0 10n
R63 63 64 1k
C63 64 0 10n
R64 64 65 1k
C64 65 0 10n
R65 65 66 1k
C65 66 0 10n
R66 66 67 1k
C66 67 0 10n
R67 67 68 1k
C67 68 0 10n
R68 68 69 1k
C68 69 0 10n
R69 69 70 1k
C69 70 0 10n
R70 70 71 1k
C70 71 0 10n
R71 71 72 1k
C71 72 0 10n
R72 72 73 1k
C72 73 0 10n
R73 73 74 1k
C73 74 0 10n
R74 74 75 1k
C74 75 0 10n
R75 75 76 1k
C75 76 0 10n
R76 76 77 1k
C76 77 0 10n
R77 77 78 1k
C77 78 0 10n
R78 78 79 1k
C78 79 0 10n
R79 79 80 1k
C79 80 0 10n
R80 80 81 1k
C80 81 0 10n
R81 81 82 1k
C81 82 0 10n
R82 82 83 1k
C82 83 0 10n
R83 83 84 1k
C83 84 0 10n
R84 84 85 1k
C84 85 0 10n
R85 85 86 1k
C85 86 0 10n
R86 86 87 1k
C86 87 0 10n
R87 87 88 1k
C87 88 0 10n
R88 88 89 1k
C88 89 0 10n
R89 89 90 1k
C89 90 0 10n
R90 90 91 1k
C90 91 0 10n
R91 91 92 1k
C91 92 0 10n
R92 92 93 1k
C92 93 0 10n
R93 93 94 1k
C93 94 0 10n
R94 94 95 1k
C94 95 0 10n
R95 95 96 1k
C95 96 0 10n
R96 96 97 1k
C96 97 0 10n
R97 97 98 1k
C97 98 0 10n
R98 98 99 1k
C98 99 0 10n
R99 99 100 1k
C99 100 0 10n
R100 100 101 1k
C100 101 0 10n
R101 101 102 1k
C101 102 0 10n
R102 102 103 1k
C102 103 0 10n
R103 103 104 1k
C103 104 0 10n
R104 104 105 1k
C104 105 0 10n
R105 105 106 1k
C105 106 0 10n
R106 106 107 1k
C106 107 0 10n
R107 107 108 1k
C107 108 0 10n
R108 108 109 1k
C108 109 0 10n
R109 109 110 1k
C109 110 0 10n
R110 110 111 1k
C110 111 0 10n
R111 111 112 1k
C111 112 0 10n
R112 112 113 1k
C112 113 0 10n
R113 113 114 1k
C113 114 0 10n
R114 114 115 1k
C114 115 0 10n
R115 115 116 1k
C115 116 0 10n
R116 116 117 1k
C116 117 0 10n
R117 117 118 1k
C117 118 0 10n
R118 118 119 1k
C118 119 0 10n
R119 119 120 1k
C119 120 0 10n
R120 120 121 1k
C120 121 0 10n
R121 121 122 1k
C121 122 0 10n
R122 122 123 1k
C122 123 0 10n
R123 123 124 1k
C123 124 0 10n
R124 124 125 1k
C124 125 0 10n
R125 125 126 1k
C125 126 0 10n
R126 126 127 1k
C126 127 0 10n
R127 127 128 1k
C127 128 0 10n
R128 128 129 1k
C128 129 0 10n
R129 129 130 1k
C129 130 0 10n
R130 130 131 1k
C130 131 0 10n
R131 131 132 1k
C131 132 0 10n
R132 132 133 1k
C132 133 0 10n
R133 133 134 1k
C133 134 0 10n
R134 134 135 1k
C134 135 0 10n
R135 135 136 1k
C135 136 0 10n
R136 136 137 1k
C136 137 0 10n
R137 137 138 1k
C137 138 0 10n
R138 138 139 1k
C138 139 0 10n
R139 139 140 1k
C139 140 0 10n
R140 140 141 1k
C140 141 0 10n
R141 141 142 1k
C141 142 0 10n
R142 142 143 1k
C142 143 0 10n
R143 143 144 1k
C143 144 0 10n
R144 144 145 1k
C144 145 0 10n
R145 145 146 1k
C145 146 0 10n
R146 146 147 1k
C146 147 0 10n
R147 147 148 1k
C147 148 0 10n
R148 148 149 1k
C148 149 0 10n
R149 149 150 1k
C149 150 0 10n
R150 150 151 1k
C150 151 0 10n
R151 151 152 1k
C151 152 0 10n
R152 152 153 1k
C152 153 0 10n
R153 153 154 1k
C153 154 0 10n
R154 154 155 1k
C154 155 0 10n
R155 155 156 1k
C155 156 0 10n
R156 156 157 1k
C156 157 0 10n
R157 157 158 1k
C157 158 0 10n
R158 158 159 1k
C158 159 0 10n
R159 159 160 1k
C159 160 0 10n
R160 160 161 1k
C160 161 0 10n
R161 161 162 1k
C161 162 0 10n
R162 162 163 1k
C162 163 0 10n
R163 163 164 1k
C163 164 0 10n
R164 164 165 1k
C164 165 0 10n
R165 165 166 1k
C165 166 0 10n
R166 166 167 1k
C166 167 0 10n
R167 167 168 1k
C167 168 0 10n
R168 168 169 1k
C168 169 0 10n
R169 169 170 1k
C169 170 0 10n
R170 170 171 1k
C170 171 0 10n
R171 171 172 1k
C171 172 0 10n
R172 172 173 1k
C172 173 0 10n
R173 173 174 1k
C173 174 0 10n
R174 174 175 1k
C174 175 0 10n
R175 175 176 1k
C175 176 0 10n
R176 176 177 1k
C176 177 0 10n
R177 177 178 1k
C177 178 0 10n
R178 178 179 1k
C178 179 0 10n
R179 179 180 1k
C179 180 0 10n
R180 180 181 1k
C180 181 0 10n
R181 181 182 1k
C181 182 0 10n
R182 182 183 1k
C182 183 0 10n
R183 183 184 1k
C183 184 0 10n
R184 184 185 1k
C184 185 0 10n
R185 185 186 1k
C185 186 0 10n
R186 186 187 1k
C186 187 0 10n
R187 187 188 1k
C187 188 0 10n
R188 188 189 1k
C188 189 0 10n
R189 189 190 1k
C189 190 0 10n
R190 190 191 1k
C190 191 0 10n
R191 191 192 1k
C191 192 0 10n
R192 192 193 1k
C192 193 0 10n
R193 193 194 1k
C193 194 0 10n
R194 194 195 1k
C194 195 0 10n
R195 195 196 1k
C195 196 0 10n
R196 196 197 1k
C196 197 0 10n
R197 197 198 1k
C197 198 0 10n
R198 198 199 1k
C198 199 0 10n
R199 199 200 1k
C199 200 0 10n
R200 200 201 1k
C200 201 0 10n

.AC DEC 1000 10 1Meg
.OPTIONS ACFREQPAR
.END
