* Benchmark e-XSpice: Filtro RLC e Ceifador a Diodos

* 1. O modelo DEVE vir com parênteses ( ) e ANTES dos diodos
.MODEL DMODEL D ( IS=1e-14 N=1.0 CJO=10p VJ=0.7 )

* 2. Fonte Senoidal: SIN VO VA FREQ
V1 1 0 SIN 0 20 1000

* 3. Estágio RLC 1
R1 1 2 100
L1 2 3 15m
C1 3 0 10u

* 4. Estágio RLC 2
R2 3 4 220
L2 4 5 5m
C2 5 0 4.7u

* 5. Ceifador a Diodos
D1 5 6 DMODEL
D2 0 5 DMODEL
Vbias 6 0 DC 5.0

* 6. Carga final
R3 5 7 1k
C3 7 0 1u
L3 7 8 1m
Rload 8 0 4.7k

* 7. Análise Transiente: step = 5us, stop = 5ms
.TRAN 5u 50m
.END
