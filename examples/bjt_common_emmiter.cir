Q1 out N003 N004 0 NPN
V1 N002 0 SINE(0 1m 1k)
R1 N003 N002 2k
R2 N004 0 2k
R3 N001 out 2k
V2 N001 0 5

.MODEL QN NPN (IS=1e-16 BF=120 NF=1 VAF=100 TF=0.3n CJE=4p VJE=0.75 MJE=0.33 CJC=2p VJC=0.75 MJC=0.33)
.MODEL QP PNP (IS=1e-16 BF=80  NF=1 VAF=60  TF=0.3n CJE=4p VJE=0.75 MJE=0.33 CJC=2p VJC=0.75 MJC=0.33)

.TRAN 20n 6u 0
.END
