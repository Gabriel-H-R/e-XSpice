* Diode-clipper ladder 500 - nonlinear MPI scaling demo
* 500 sections x (R + D + C) = 1501 devices

.MODEL DMOD D (IS=1e-14 N=1.0 CJO=10p VJ=0.7)

V1 1 0 PULSE(0 5 0 10u 10u 500u 1m)
R1 1 2 1k
D1 2 0 DMOD
C1 2 0 10n
R2 2 3 1k
D2 3 0 DMOD
C2 3 0 10n
R3 3 4 1k
D3 4 0 DMOD
C3 4 0 10n
R4 4 5 1k
D4 5 0 DMOD
C4 5 0 10n
R5 5 6 1k
D5 6 0 DMOD
C5 6 0 10n
R6 6 7 1k
D6 7 0 DMOD
C6 7 0 10n
R7 7 8 1k
D7 8 0 DMOD
C7 8 0 10n
R8 8 9 1k
D8 9 0 DMOD
C8 9 0 10n
R9 9 10 1k
D9 10 0 DMOD
C9 10 0 10n
R10 10 11 1k
D10 11 0 DMOD
C10 11 0 10n
R11 11 12 1k
D11 12 0 DMOD
C11 12 0 10n
R12 12 13 1k
D12 13 0 DMOD
C12 13 0 10n
R13 13 14 1k
D13 14 0 DMOD
C13 14 0 10n
R14 14 15 1k
D14 15 0 DMOD
C14 15 0 10n
R15 15 16 1k
D15 16 0 DMOD
C15 16 0 10n
R16 16 17 1k
D16 17 0 DMOD
C16 17 0 10n
R17 17 18 1k
D17 18 0 DMOD
C17 18 0 10n
R18 18 19 1k
D18 19 0 DMOD
C18 19 0 10n
R19 19 20 1k
D19 20 0 DMOD
C19 20 0 10n
R20 20 21 1k
D20 21 0 DMOD
C20 21 0 10n
R21 21 22 1k
D21 22 0 DMOD
C21 22 0 10n
R22 22 23 1k
D22 23 0 DMOD
C22 23 0 10n
R23 23 24 1k
D23 24 0 DMOD
C23 24 0 10n
R24 24 25 1k
D24 25 0 DMOD
C24 25 0 10n
R25 25 26 1k
D25 26 0 DMOD
C25 26 0 10n
R26 26 27 1k
D26 27 0 DMOD
C26 27 0 10n
R27 27 28 1k
D27 28 0 DMOD
C27 28 0 10n
R28 28 29 1k
D28 29 0 DMOD
C28 29 0 10n
R29 29 30 1k
D29 30 0 DMOD
C29 30 0 10n
R30 30 31 1k
D30 31 0 DMOD
C30 31 0 10n
R31 31 32 1k
D31 32 0 DMOD
C31 32 0 10n
R32 32 33 1k
D32 33 0 DMOD
C32 33 0 10n
R33 33 34 1k
D33 34 0 DMOD
C33 34 0 10n
R34 34 35 1k
D34 35 0 DMOD
C34 35 0 10n
R35 35 36 1k
D35 36 0 DMOD
C35 36 0 10n
R36 36 37 1k
D36 37 0 DMOD
C36 37 0 10n
R37 37 38 1k
D37 38 0 DMOD
C37 38 0 10n
R38 38 39 1k
D38 39 0 DMOD
C38 39 0 10n
R39 39 40 1k
D39 40 0 DMOD
C39 40 0 10n
R40 40 41 1k
D40 41 0 DMOD
C40 41 0 10n
R41 41 42 1k
D41 42 0 DMOD
C41 42 0 10n
R42 42 43 1k
D42 43 0 DMOD
C42 43 0 10n
R43 43 44 1k
D43 44 0 DMOD
C43 44 0 10n
R44 44 45 1k
D44 45 0 DMOD
C44 45 0 10n
R45 45 46 1k
D45 46 0 DMOD
C45 46 0 10n
R46 46 47 1k
D46 47 0 DMOD
C46 47 0 10n
R47 47 48 1k
D47 48 0 DMOD
C47 48 0 10n
R48 48 49 1k
D48 49 0 DMOD
C48 49 0 10n
R49 49 50 1k
D49 50 0 DMOD
C49 50 0 10n
R50 50 51 1k
D50 51 0 DMOD
C50 51 0 10n
R51 51 52 1k
D51 52 0 DMOD
C51 52 0 10n
R52 52 53 1k
D52 53 0 DMOD
C52 53 0 10n
R53 53 54 1k
D53 54 0 DMOD
C53 54 0 10n
R54 54 55 1k
D54 55 0 DMOD
C54 55 0 10n
R55 55 56 1k
D55 56 0 DMOD
C55 56 0 10n
R56 56 57 1k
D56 57 0 DMOD
C56 57 0 10n
R57 57 58 1k
D57 58 0 DMOD
C57 58 0 10n
R58 58 59 1k
D58 59 0 DMOD
C58 59 0 10n
R59 59 60 1k
D59 60 0 DMOD
C59 60 0 10n
R60 60 61 1k
D60 61 0 DMOD
C60 61 0 10n
R61 61 62 1k
D61 62 0 DMOD
C61 62 0 10n
R62 62 63 1k
D62 63 0 DMOD
C62 63 0 10n
R63 63 64 1k
D63 64 0 DMOD
C63 64 0 10n
R64 64 65 1k
D64 65 0 DMOD
C64 65 0 10n
R65 65 66 1k
D65 66 0 DMOD
C65 66 0 10n
R66 66 67 1k
D66 67 0 DMOD
C66 67 0 10n
R67 67 68 1k
D67 68 0 DMOD
C67 68 0 10n
R68 68 69 1k
D68 69 0 DMOD
C68 69 0 10n
R69 69 70 1k
D69 70 0 DMOD
C69 70 0 10n
R70 70 71 1k
D70 71 0 DMOD
C70 71 0 10n
R71 71 72 1k
D71 72 0 DMOD
C71 72 0 10n
R72 72 73 1k
D72 73 0 DMOD
C72 73 0 10n
R73 73 74 1k
D73 74 0 DMOD
C73 74 0 10n
R74 74 75 1k
D74 75 0 DMOD
C74 75 0 10n
R75 75 76 1k
D75 76 0 DMOD
C75 76 0 10n
R76 76 77 1k
D76 77 0 DMOD
C76 77 0 10n
R77 77 78 1k
D77 78 0 DMOD
C77 78 0 10n
R78 78 79 1k
D78 79 0 DMOD
C78 79 0 10n
R79 79 80 1k
D79 80 0 DMOD
C79 80 0 10n
R80 80 81 1k
D80 81 0 DMOD
C80 81 0 10n
R81 81 82 1k
D81 82 0 DMOD
C81 82 0 10n
R82 82 83 1k
D82 83 0 DMOD
C82 83 0 10n
R83 83 84 1k
D83 84 0 DMOD
C83 84 0 10n
R84 84 85 1k
D84 85 0 DMOD
C84 85 0 10n
R85 85 86 1k
D85 86 0 DMOD
C85 86 0 10n
R86 86 87 1k
D86 87 0 DMOD
C86 87 0 10n
R87 87 88 1k
D87 88 0 DMOD
C87 88 0 10n
R88 88 89 1k
D88 89 0 DMOD
C88 89 0 10n
R89 89 90 1k
D89 90 0 DMOD
C89 90 0 10n
R90 90 91 1k
D90 91 0 DMOD
C90 91 0 10n
R91 91 92 1k
D91 92 0 DMOD
C91 92 0 10n
R92 92 93 1k
D92 93 0 DMOD
C92 93 0 10n
R93 93 94 1k
D93 94 0 DMOD
C93 94 0 10n
R94 94 95 1k
D94 95 0 DMOD
C94 95 0 10n
R95 95 96 1k
D95 96 0 DMOD
C95 96 0 10n
R96 96 97 1k
D96 97 0 DMOD
C96 97 0 10n
R97 97 98 1k
D97 98 0 DMOD
C97 98 0 10n
R98 98 99 1k
D98 99 0 DMOD
C98 99 0 10n
R99 99 100 1k
D99 100 0 DMOD
C99 100 0 10n
R100 100 101 1k
D100 101 0 DMOD
C100 101 0 10n
R101 101 102 1k
D101 102 0 DMOD
C101 102 0 10n
R102 102 103 1k
D102 103 0 DMOD
C102 103 0 10n
R103 103 104 1k
D103 104 0 DMOD
C103 104 0 10n
R104 104 105 1k
D104 105 0 DMOD
C104 105 0 10n
R105 105 106 1k
D105 106 0 DMOD
C105 106 0 10n
R106 106 107 1k
D106 107 0 DMOD
C106 107 0 10n
R107 107 108 1k
D107 108 0 DMOD
C107 108 0 10n
R108 108 109 1k
D108 109 0 DMOD
C108 109 0 10n
R109 109 110 1k
D109 110 0 DMOD
C109 110 0 10n
R110 110 111 1k
D110 111 0 DMOD
C110 111 0 10n
R111 111 112 1k
D111 112 0 DMOD
C111 112 0 10n
R112 112 113 1k
D112 113 0 DMOD
C112 113 0 10n
R113 113 114 1k
D113 114 0 DMOD
C113 114 0 10n
R114 114 115 1k
D114 115 0 DMOD
C114 115 0 10n
R115 115 116 1k
D115 116 0 DMOD
C115 116 0 10n
R116 116 117 1k
D116 117 0 DMOD
C116 117 0 10n
R117 117 118 1k
D117 118 0 DMOD
C117 118 0 10n
R118 118 119 1k
D118 119 0 DMOD
C118 119 0 10n
R119 119 120 1k
D119 120 0 DMOD
C119 120 0 10n
R120 120 121 1k
D120 121 0 DMOD
C120 121 0 10n
R121 121 122 1k
D121 122 0 DMOD
C121 122 0 10n
R122 122 123 1k
D122 123 0 DMOD
C122 123 0 10n
R123 123 124 1k
D123 124 0 DMOD
C123 124 0 10n
R124 124 125 1k
D124 125 0 DMOD
C124 125 0 10n
R125 125 126 1k
D125 126 0 DMOD
C125 126 0 10n
R126 126 127 1k
D126 127 0 DMOD
C126 127 0 10n
R127 127 128 1k
D127 128 0 DMOD
C127 128 0 10n
R128 128 129 1k
D128 129 0 DMOD
C128 129 0 10n
R129 129 130 1k
D129 130 0 DMOD
C129 130 0 10n
R130 130 131 1k
D130 131 0 DMOD
C130 131 0 10n
R131 131 132 1k
D131 132 0 DMOD
C131 132 0 10n
R132 132 133 1k
D132 133 0 DMOD
C132 133 0 10n
R133 133 134 1k
D133 134 0 DMOD
C133 134 0 10n
R134 134 135 1k
D134 135 0 DMOD
C134 135 0 10n
R135 135 136 1k
D135 136 0 DMOD
C135 136 0 10n
R136 136 137 1k
D136 137 0 DMOD
C136 137 0 10n
R137 137 138 1k
D137 138 0 DMOD
C137 138 0 10n
R138 138 139 1k
D138 139 0 DMOD
C138 139 0 10n
R139 139 140 1k
D139 140 0 DMOD
C139 140 0 10n
R140 140 141 1k
D140 141 0 DMOD
C140 141 0 10n
R141 141 142 1k
D141 142 0 DMOD
C141 142 0 10n
R142 142 143 1k
D142 143 0 DMOD
C142 143 0 10n
R143 143 144 1k
D143 144 0 DMOD
C143 144 0 10n
R144 144 145 1k
D144 145 0 DMOD
C144 145 0 10n
R145 145 146 1k
D145 146 0 DMOD
C145 146 0 10n
R146 146 147 1k
D146 147 0 DMOD
C146 147 0 10n
R147 147 148 1k
D147 148 0 DMOD
C147 148 0 10n
R148 148 149 1k
D148 149 0 DMOD
C148 149 0 10n
R149 149 150 1k
D149 150 0 DMOD
C149 150 0 10n
R150 150 151 1k
D150 151 0 DMOD
C150 151 0 10n
R151 151 152 1k
D151 152 0 DMOD
C151 152 0 10n
R152 152 153 1k
D152 153 0 DMOD
C152 153 0 10n
R153 153 154 1k
D153 154 0 DMOD
C153 154 0 10n
R154 154 155 1k
D154 155 0 DMOD
C154 155 0 10n
R155 155 156 1k
D155 156 0 DMOD
C155 156 0 10n
R156 156 157 1k
D156 157 0 DMOD
C156 157 0 10n
R157 157 158 1k
D157 158 0 DMOD
C157 158 0 10n
R158 158 159 1k
D158 159 0 DMOD
C158 159 0 10n
R159 159 160 1k
D159 160 0 DMOD
C159 160 0 10n
R160 160 161 1k
D160 161 0 DMOD
C160 161 0 10n
R161 161 162 1k
D161 162 0 DMOD
C161 162 0 10n
R162 162 163 1k
D162 163 0 DMOD
C162 163 0 10n
R163 163 164 1k
D163 164 0 DMOD
C163 164 0 10n
R164 164 165 1k
D164 165 0 DMOD
C164 165 0 10n
R165 165 166 1k
D165 166 0 DMOD
C165 166 0 10n
R166 166 167 1k
D166 167 0 DMOD
C166 167 0 10n
R167 167 168 1k
D167 168 0 DMOD
C167 168 0 10n
R168 168 169 1k
D168 169 0 DMOD
C168 169 0 10n
R169 169 170 1k
D169 170 0 DMOD
C169 170 0 10n
R170 170 171 1k
D170 171 0 DMOD
C170 171 0 10n
R171 171 172 1k
D171 172 0 DMOD
C171 172 0 10n
R172 172 173 1k
D172 173 0 DMOD
C172 173 0 10n
R173 173 174 1k
D173 174 0 DMOD
C173 174 0 10n
R174 174 175 1k
D174 175 0 DMOD
C174 175 0 10n
R175 175 176 1k
D175 176 0 DMOD
C175 176 0 10n
R176 176 177 1k
D176 177 0 DMOD
C176 177 0 10n
R177 177 178 1k
D177 178 0 DMOD
C177 178 0 10n
R178 178 179 1k
D178 179 0 DMOD
C178 179 0 10n
R179 179 180 1k
D179 180 0 DMOD
C179 180 0 10n
R180 180 181 1k
D180 181 0 DMOD
C180 181 0 10n
R181 181 182 1k
D181 182 0 DMOD
C181 182 0 10n
R182 182 183 1k
D182 183 0 DMOD
C182 183 0 10n
R183 183 184 1k
D183 184 0 DMOD
C183 184 0 10n
R184 184 185 1k
D184 185 0 DMOD
C184 185 0 10n
R185 185 186 1k
D185 186 0 DMOD
C185 186 0 10n
R186 186 187 1k
D186 187 0 DMOD
C186 187 0 10n
R187 187 188 1k
D187 188 0 DMOD
C187 188 0 10n
R188 188 189 1k
D188 189 0 DMOD
C188 189 0 10n
R189 189 190 1k
D189 190 0 DMOD
C189 190 0 10n
R190 190 191 1k
D190 191 0 DMOD
C190 191 0 10n
R191 191 192 1k
D191 192 0 DMOD
C191 192 0 10n
R192 192 193 1k
D192 193 0 DMOD
C192 193 0 10n
R193 193 194 1k
D193 194 0 DMOD
C193 194 0 10n
R194 194 195 1k
D194 195 0 DMOD
C194 195 0 10n
R195 195 196 1k
D195 196 0 DMOD
C195 196 0 10n
R196 196 197 1k
D196 197 0 DMOD
C196 197 0 10n
R197 197 198 1k
D197 198 0 DMOD
C197 198 0 10n
R198 198 199 1k
D198 199 0 DMOD
C198 199 0 10n
R199 199 200 1k
D199 200 0 DMOD
C199 200 0 10n
R200 200 201 1k
D200 201 0 DMOD
C200 201 0 10n
R201 201 202 1k
D201 202 0 DMOD
C201 202 0 10n
R202 202 203 1k
D202 203 0 DMOD
C202 203 0 10n
R203 203 204 1k
D203 204 0 DMOD
C203 204 0 10n
R204 204 205 1k
D204 205 0 DMOD
C204 205 0 10n
R205 205 206 1k
D205 206 0 DMOD
C205 206 0 10n
R206 206 207 1k
D206 207 0 DMOD
C206 207 0 10n
R207 207 208 1k
D207 208 0 DMOD
C207 208 0 10n
R208 208 209 1k
D208 209 0 DMOD
C208 209 0 10n
R209 209 210 1k
D209 210 0 DMOD
C209 210 0 10n
R210 210 211 1k
D210 211 0 DMOD
C210 211 0 10n
R211 211 212 1k
D211 212 0 DMOD
C211 212 0 10n
R212 212 213 1k
D212 213 0 DMOD
C212 213 0 10n
R213 213 214 1k
D213 214 0 DMOD
C213 214 0 10n
R214 214 215 1k
D214 215 0 DMOD
C214 215 0 10n
R215 215 216 1k
D215 216 0 DMOD
C215 216 0 10n
R216 216 217 1k
D216 217 0 DMOD
C216 217 0 10n
R217 217 218 1k
D217 218 0 DMOD
C217 218 0 10n
R218 218 219 1k
D218 219 0 DMOD
C218 219 0 10n
R219 219 220 1k
D219 220 0 DMOD
C219 220 0 10n
R220 220 221 1k
D220 221 0 DMOD
C220 221 0 10n
R221 221 222 1k
D221 222 0 DMOD
C221 222 0 10n
R222 222 223 1k
D222 223 0 DMOD
C222 223 0 10n
R223 223 224 1k
D223 224 0 DMOD
C223 224 0 10n
R224 224 225 1k
D224 225 0 DMOD
C224 225 0 10n
R225 225 226 1k
D225 226 0 DMOD
C225 226 0 10n
R226 226 227 1k
D226 227 0 DMOD
C226 227 0 10n
R227 227 228 1k
D227 228 0 DMOD
C227 228 0 10n
R228 228 229 1k
D228 229 0 DMOD
C228 229 0 10n
R229 229 230 1k
D229 230 0 DMOD
C229 230 0 10n
R230 230 231 1k
D230 231 0 DMOD
C230 231 0 10n
R231 231 232 1k
D231 232 0 DMOD
C231 232 0 10n
R232 232 233 1k
D232 233 0 DMOD
C232 233 0 10n
R233 233 234 1k
D233 234 0 DMOD
C233 234 0 10n
R234 234 235 1k
D234 235 0 DMOD
C234 235 0 10n
R235 235 236 1k
D235 236 0 DMOD
C235 236 0 10n
R236 236 237 1k
D236 237 0 DMOD
C236 237 0 10n
R237 237 238 1k
D237 238 0 DMOD
C237 238 0 10n
R238 238 239 1k
D238 239 0 DMOD
C238 239 0 10n
R239 239 240 1k
D239 240 0 DMOD
C239 240 0 10n
R240 240 241 1k
D240 241 0 DMOD
C240 241 0 10n
R241 241 242 1k
D241 242 0 DMOD
C241 242 0 10n
R242 242 243 1k
D242 243 0 DMOD
C242 243 0 10n
R243 243 244 1k
D243 244 0 DMOD
C243 244 0 10n
R244 244 245 1k
D244 245 0 DMOD
C244 245 0 10n
R245 245 246 1k
D245 246 0 DMOD
C245 246 0 10n
R246 246 247 1k
D246 247 0 DMOD
C246 247 0 10n
R247 247 248 1k
D247 248 0 DMOD
C247 248 0 10n
R248 248 249 1k
D248 249 0 DMOD
C248 249 0 10n
R249 249 250 1k
D249 250 0 DMOD
C249 250 0 10n
R250 250 251 1k
D250 251 0 DMOD
C250 251 0 10n
R251 251 252 1k
D251 252 0 DMOD
C251 252 0 10n
R252 252 253 1k
D252 253 0 DMOD
C252 253 0 10n
R253 253 254 1k
D253 254 0 DMOD
C253 254 0 10n
R254 254 255 1k
D254 255 0 DMOD
C254 255 0 10n
R255 255 256 1k
D255 256 0 DMOD
C255 256 0 10n
R256 256 257 1k
D256 257 0 DMOD
C256 257 0 10n
R257 257 258 1k
D257 258 0 DMOD
C257 258 0 10n
R258 258 259 1k
D258 259 0 DMOD
C258 259 0 10n
R259 259 260 1k
D259 260 0 DMOD
C259 260 0 10n
R260 260 261 1k
D260 261 0 DMOD
C260 261 0 10n
R261 261 262 1k
D261 262 0 DMOD
C261 262 0 10n
R262 262 263 1k
D262 263 0 DMOD
C262 263 0 10n
R263 263 264 1k
D263 264 0 DMOD
C263 264 0 10n
R264 264 265 1k
D264 265 0 DMOD
C264 265 0 10n
R265 265 266 1k
D265 266 0 DMOD
C265 266 0 10n
R266 266 267 1k
D266 267 0 DMOD
C266 267 0 10n
R267 267 268 1k
D267 268 0 DMOD
C267 268 0 10n
R268 268 269 1k
D268 269 0 DMOD
C268 269 0 10n
R269 269 270 1k
D269 270 0 DMOD
C269 270 0 10n
R270 270 271 1k
D270 271 0 DMOD
C270 271 0 10n
R271 271 272 1k
D271 272 0 DMOD
C271 272 0 10n
R272 272 273 1k
D272 273 0 DMOD
C272 273 0 10n
R273 273 274 1k
D273 274 0 DMOD
C273 274 0 10n
R274 274 275 1k
D274 275 0 DMOD
C274 275 0 10n
R275 275 276 1k
D275 276 0 DMOD
C275 276 0 10n
R276 276 277 1k
D276 277 0 DMOD
C276 277 0 10n
R277 277 278 1k
D277 278 0 DMOD
C277 278 0 10n
R278 278 279 1k
D278 279 0 DMOD
C278 279 0 10n
R279 279 280 1k
D279 280 0 DMOD
C279 280 0 10n
R280 280 281 1k
D280 281 0 DMOD
C280 281 0 10n
R281 281 282 1k
D281 282 0 DMOD
C281 282 0 10n
R282 282 283 1k
D282 283 0 DMOD
C282 283 0 10n
R283 283 284 1k
D283 284 0 DMOD
C283 284 0 10n
R284 284 285 1k
D284 285 0 DMOD
C284 285 0 10n
R285 285 286 1k
D285 286 0 DMOD
C285 286 0 10n
R286 286 287 1k
D286 287 0 DMOD
C286 287 0 10n
R287 287 288 1k
D287 288 0 DMOD
C287 288 0 10n
R288 288 289 1k
D288 289 0 DMOD
C288 289 0 10n
R289 289 290 1k
D289 290 0 DMOD
C289 290 0 10n
R290 290 291 1k
D290 291 0 DMOD
C290 291 0 10n
R291 291 292 1k
D291 292 0 DMOD
C291 292 0 10n
R292 292 293 1k
D292 293 0 DMOD
C292 293 0 10n
R293 293 294 1k
D293 294 0 DMOD
C293 294 0 10n
R294 294 295 1k
D294 295 0 DMOD
C294 295 0 10n
R295 295 296 1k
D295 296 0 DMOD
C295 296 0 10n
R296 296 297 1k
D296 297 0 DMOD
C296 297 0 10n
R297 297 298 1k
D297 298 0 DMOD
C297 298 0 10n
R298 298 299 1k
D298 299 0 DMOD
C298 299 0 10n
R299 299 300 1k
D299 300 0 DMOD
C299 300 0 10n
R300 300 301 1k
D300 301 0 DMOD
C300 301 0 10n
R301 301 302 1k
D301 302 0 DMOD
C301 302 0 10n
R302 302 303 1k
D302 303 0 DMOD
C302 303 0 10n
R303 303 304 1k
D303 304 0 DMOD
C303 304 0 10n
R304 304 305 1k
D304 305 0 DMOD
C304 305 0 10n
R305 305 306 1k
D305 306 0 DMOD
C305 306 0 10n
R306 306 307 1k
D306 307 0 DMOD
C306 307 0 10n
R307 307 308 1k
D307 308 0 DMOD
C307 308 0 10n
R308 308 309 1k
D308 309 0 DMOD
C308 309 0 10n
R309 309 310 1k
D309 310 0 DMOD
C309 310 0 10n
R310 310 311 1k
D310 311 0 DMOD
C310 311 0 10n
R311 311 312 1k
D311 312 0 DMOD
C311 312 0 10n
R312 312 313 1k
D312 313 0 DMOD
C312 313 0 10n
R313 313 314 1k
D313 314 0 DMOD
C313 314 0 10n
R314 314 315 1k
D314 315 0 DMOD
C314 315 0 10n
R315 315 316 1k
D315 316 0 DMOD
C315 316 0 10n
R316 316 317 1k
D316 317 0 DMOD
C316 317 0 10n
R317 317 318 1k
D317 318 0 DMOD
C317 318 0 10n
R318 318 319 1k
D318 319 0 DMOD
C318 319 0 10n
R319 319 320 1k
D319 320 0 DMOD
C319 320 0 10n
R320 320 321 1k
D320 321 0 DMOD
C320 321 0 10n
R321 321 322 1k
D321 322 0 DMOD
C321 322 0 10n
R322 322 323 1k
D322 323 0 DMOD
C322 323 0 10n
R323 323 324 1k
D323 324 0 DMOD
C323 324 0 10n
R324 324 325 1k
D324 325 0 DMOD
C324 325 0 10n
R325 325 326 1k
D325 326 0 DMOD
C325 326 0 10n
R326 326 327 1k
D326 327 0 DMOD
C326 327 0 10n
R327 327 328 1k
D327 328 0 DMOD
C327 328 0 10n
R328 328 329 1k
D328 329 0 DMOD
C328 329 0 10n
R329 329 330 1k
D329 330 0 DMOD
C329 330 0 10n
R330 330 331 1k
D330 331 0 DMOD
C330 331 0 10n
R331 331 332 1k
D331 332 0 DMOD
C331 332 0 10n
R332 332 333 1k
D332 333 0 DMOD
C332 333 0 10n
R333 333 334 1k
D333 334 0 DMOD
C333 334 0 10n
R334 334 335 1k
D334 335 0 DMOD
C334 335 0 10n
R335 335 336 1k
D335 336 0 DMOD
C335 336 0 10n
R336 336 337 1k
D336 337 0 DMOD
C336 337 0 10n
R337 337 338 1k
D337 338 0 DMOD
C337 338 0 10n
R338 338 339 1k
D338 339 0 DMOD
C338 339 0 10n
R339 339 340 1k
D339 340 0 DMOD
C339 340 0 10n
R340 340 341 1k
D340 341 0 DMOD
C340 341 0 10n
R341 341 342 1k
D341 342 0 DMOD
C341 342 0 10n
R342 342 343 1k
D342 343 0 DMOD
C342 343 0 10n
R343 343 344 1k
D343 344 0 DMOD
C343 344 0 10n
R344 344 345 1k
D344 345 0 DMOD
C344 345 0 10n
R345 345 346 1k
D345 346 0 DMOD
C345 346 0 10n
R346 346 347 1k
D346 347 0 DMOD
C346 347 0 10n
R347 347 348 1k
D347 348 0 DMOD
C347 348 0 10n
R348 348 349 1k
D348 349 0 DMOD
C348 349 0 10n
R349 349 350 1k
D349 350 0 DMOD
C349 350 0 10n
R350 350 351 1k
D350 351 0 DMOD
C350 351 0 10n
R351 351 352 1k
D351 352 0 DMOD
C351 352 0 10n
R352 352 353 1k
D352 353 0 DMOD
C352 353 0 10n
R353 353 354 1k
D353 354 0 DMOD
C353 354 0 10n
R354 354 355 1k
D354 355 0 DMOD
C354 355 0 10n
R355 355 356 1k
D355 356 0 DMOD
C355 356 0 10n
R356 356 357 1k
D356 357 0 DMOD
C356 357 0 10n
R357 357 358 1k
D357 358 0 DMOD
C357 358 0 10n
R358 358 359 1k
D358 359 0 DMOD
C358 359 0 10n
R359 359 360 1k
D359 360 0 DMOD
C359 360 0 10n
R360 360 361 1k
D360 361 0 DMOD
C360 361 0 10n
R361 361 362 1k
D361 362 0 DMOD
C361 362 0 10n
R362 362 363 1k
D362 363 0 DMOD
C362 363 0 10n
R363 363 364 1k
D363 364 0 DMOD
C363 364 0 10n
R364 364 365 1k
D364 365 0 DMOD
C364 365 0 10n
R365 365 366 1k
D365 366 0 DMOD
C365 366 0 10n
R366 366 367 1k
D366 367 0 DMOD
C366 367 0 10n
R367 367 368 1k
D367 368 0 DMOD
C367 368 0 10n
R368 368 369 1k
D368 369 0 DMOD
C368 369 0 10n
R369 369 370 1k
D369 370 0 DMOD
C369 370 0 10n
R370 370 371 1k
D370 371 0 DMOD
C370 371 0 10n
R371 371 372 1k
D371 372 0 DMOD
C371 372 0 10n
R372 372 373 1k
D372 373 0 DMOD
C372 373 0 10n
R373 373 374 1k
D373 374 0 DMOD
C373 374 0 10n
R374 374 375 1k
D374 375 0 DMOD
C374 375 0 10n
R375 375 376 1k
D375 376 0 DMOD
C375 376 0 10n
R376 376 377 1k
D376 377 0 DMOD
C376 377 0 10n
R377 377 378 1k
D377 378 0 DMOD
C377 378 0 10n
R378 378 379 1k
D378 379 0 DMOD
C378 379 0 10n
R379 379 380 1k
D379 380 0 DMOD
C379 380 0 10n
R380 380 381 1k
D380 381 0 DMOD
C380 381 0 10n
R381 381 382 1k
D381 382 0 DMOD
C381 382 0 10n
R382 382 383 1k
D382 383 0 DMOD
C382 383 0 10n
R383 383 384 1k
D383 384 0 DMOD
C383 384 0 10n
R384 384 385 1k
D384 385 0 DMOD
C384 385 0 10n
R385 385 386 1k
D385 386 0 DMOD
C385 386 0 10n
R386 386 387 1k
D386 387 0 DMOD
C386 387 0 10n
R387 387 388 1k
D387 388 0 DMOD
C387 388 0 10n
R388 388 389 1k
D388 389 0 DMOD
C388 389 0 10n
R389 389 390 1k
D389 390 0 DMOD
C389 390 0 10n
R390 390 391 1k
D390 391 0 DMOD
C390 391 0 10n
R391 391 392 1k
D391 392 0 DMOD
C391 392 0 10n
R392 392 393 1k
D392 393 0 DMOD
C392 393 0 10n
R393 393 394 1k
D393 394 0 DMOD
C393 394 0 10n
R394 394 395 1k
D394 395 0 DMOD
C394 395 0 10n
R395 395 396 1k
D395 396 0 DMOD
C395 396 0 10n
R396 396 397 1k
D396 397 0 DMOD
C396 397 0 10n
R397 397 398 1k
D397 398 0 DMOD
C397 398 0 10n
R398 398 399 1k
D398 399 0 DMOD
C398 399 0 10n
R399 399 400 1k
D399 400 0 DMOD
C399 400 0 10n
R400 400 401 1k
D400 401 0 DMOD
C400 401 0 10n
R401 401 402 1k
D401 402 0 DMOD
C401 402 0 10n
R402 402 403 1k
D402 403 0 DMOD
C402 403 0 10n
R403 403 404 1k
D403 404 0 DMOD
C403 404 0 10n
R404 404 405 1k
D404 405 0 DMOD
C404 405 0 10n
R405 405 406 1k
D405 406 0 DMOD
C405 406 0 10n
R406 406 407 1k
D406 407 0 DMOD
C406 407 0 10n
R407 407 408 1k
D407 408 0 DMOD
C407 408 0 10n
R408 408 409 1k
D408 409 0 DMOD
C408 409 0 10n
R409 409 410 1k
D409 410 0 DMOD
C409 410 0 10n
R410 410 411 1k
D410 411 0 DMOD
C410 411 0 10n
R411 411 412 1k
D411 412 0 DMOD
C411 412 0 10n
R412 412 413 1k
D412 413 0 DMOD
C412 413 0 10n
R413 413 414 1k
D413 414 0 DMOD
C413 414 0 10n
R414 414 415 1k
D414 415 0 DMOD
C414 415 0 10n
R415 415 416 1k
D415 416 0 DMOD
C415 416 0 10n
R416 416 417 1k
D416 417 0 DMOD
C416 417 0 10n
R417 417 418 1k
D417 418 0 DMOD
C417 418 0 10n
R418 418 419 1k
D418 419 0 DMOD
C418 419 0 10n
R419 419 420 1k
D419 420 0 DMOD
C419 420 0 10n
R420 420 421 1k
D420 421 0 DMOD
C420 421 0 10n
R421 421 422 1k
D421 422 0 DMOD
C421 422 0 10n
R422 422 423 1k
D422 423 0 DMOD
C422 423 0 10n
R423 423 424 1k
D423 424 0 DMOD
C423 424 0 10n
R424 424 425 1k
D424 425 0 DMOD
C424 425 0 10n
R425 425 426 1k
D425 426 0 DMOD
C425 426 0 10n
R426 426 427 1k
D426 427 0 DMOD
C426 427 0 10n
R427 427 428 1k
D427 428 0 DMOD
C427 428 0 10n
R428 428 429 1k
D428 429 0 DMOD
C428 429 0 10n
R429 429 430 1k
D429 430 0 DMOD
C429 430 0 10n
R430 430 431 1k
D430 431 0 DMOD
C430 431 0 10n
R431 431 432 1k
D431 432 0 DMOD
C431 432 0 10n
R432 432 433 1k
D432 433 0 DMOD
C432 433 0 10n
R433 433 434 1k
D433 434 0 DMOD
C433 434 0 10n
R434 434 435 1k
D434 435 0 DMOD
C434 435 0 10n
R435 435 436 1k
D435 436 0 DMOD
C435 436 0 10n
R436 436 437 1k
D436 437 0 DMOD
C436 437 0 10n
R437 437 438 1k
D437 438 0 DMOD
C437 438 0 10n
R438 438 439 1k
D438 439 0 DMOD
C438 439 0 10n
R439 439 440 1k
D439 440 0 DMOD
C439 440 0 10n
R440 440 441 1k
D440 441 0 DMOD
C440 441 0 10n
R441 441 442 1k
D441 442 0 DMOD
C441 442 0 10n
R442 442 443 1k
D442 443 0 DMOD
C442 443 0 10n
R443 443 444 1k
D443 444 0 DMOD
C443 444 0 10n
R444 444 445 1k
D444 445 0 DMOD
C444 445 0 10n
R445 445 446 1k
D445 446 0 DMOD
C445 446 0 10n
R446 446 447 1k
D446 447 0 DMOD
C446 447 0 10n
R447 447 448 1k
D447 448 0 DMOD
C447 448 0 10n
R448 448 449 1k
D448 449 0 DMOD
C448 449 0 10n
R449 449 450 1k
D449 450 0 DMOD
C449 450 0 10n
R450 450 451 1k
D450 451 0 DMOD
C450 451 0 10n
R451 451 452 1k
D451 452 0 DMOD
C451 452 0 10n
R452 452 453 1k
D452 453 0 DMOD
C452 453 0 10n
R453 453 454 1k
D453 454 0 DMOD
C453 454 0 10n
R454 454 455 1k
D454 455 0 DMOD
C454 455 0 10n
R455 455 456 1k
D455 456 0 DMOD
C455 456 0 10n
R456 456 457 1k
D456 457 0 DMOD
C456 457 0 10n
R457 457 458 1k
D457 458 0 DMOD
C457 458 0 10n
R458 458 459 1k
D458 459 0 DMOD
C458 459 0 10n
R459 459 460 1k
D459 460 0 DMOD
C459 460 0 10n
R460 460 461 1k
D460 461 0 DMOD
C460 461 0 10n
R461 461 462 1k
D461 462 0 DMOD
C461 462 0 10n
R462 462 463 1k
D462 463 0 DMOD
C462 463 0 10n
R463 463 464 1k
D463 464 0 DMOD
C463 464 0 10n
R464 464 465 1k
D464 465 0 DMOD
C464 465 0 10n
R465 465 466 1k
D465 466 0 DMOD
C465 466 0 10n
R466 466 467 1k
D466 467 0 DMOD
C466 467 0 10n
R467 467 468 1k
D467 468 0 DMOD
C467 468 0 10n
R468 468 469 1k
D468 469 0 DMOD
C468 469 0 10n
R469 469 470 1k
D469 470 0 DMOD
C469 470 0 10n
R470 470 471 1k
D470 471 0 DMOD
C470 471 0 10n
R471 471 472 1k
D471 472 0 DMOD
C471 472 0 10n
R472 472 473 1k
D472 473 0 DMOD
C472 473 0 10n
R473 473 474 1k
D473 474 0 DMOD
C473 474 0 10n
R474 474 475 1k
D474 475 0 DMOD
C474 475 0 10n
R475 475 476 1k
D475 476 0 DMOD
C475 476 0 10n
R476 476 477 1k
D476 477 0 DMOD
C476 477 0 10n
R477 477 478 1k
D477 478 0 DMOD
C477 478 0 10n
R478 478 479 1k
D478 479 0 DMOD
C478 479 0 10n
R479 479 480 1k
D479 480 0 DMOD
C479 480 0 10n
R480 480 481 1k
D480 481 0 DMOD
C480 481 0 10n
R481 481 482 1k
D481 482 0 DMOD
C481 482 0 10n
R482 482 483 1k
D482 483 0 DMOD
C482 483 0 10n
R483 483 484 1k
D483 484 0 DMOD
C483 484 0 10n
R484 484 485 1k
D484 485 0 DMOD
C484 485 0 10n
R485 485 486 1k
D485 486 0 DMOD
C485 486 0 10n
R486 486 487 1k
D486 487 0 DMOD
C486 487 0 10n
R487 487 488 1k
D487 488 0 DMOD
C487 488 0 10n
R488 488 489 1k
D488 489 0 DMOD
C488 489 0 10n
R489 489 490 1k
D489 490 0 DMOD
C489 490 0 10n
R490 490 491 1k
D490 491 0 DMOD
C490 491 0 10n
R491 491 492 1k
D491 492 0 DMOD
C491 492 0 10n
R492 492 493 1k
D492 493 0 DMOD
C492 493 0 10n
R493 493 494 1k
D493 494 0 DMOD
C493 494 0 10n
R494 494 495 1k
D494 495 0 DMOD
C494 495 0 10n
R495 495 496 1k
D495 496 0 DMOD
C495 496 0 10n
R496 496 497 1k
D496 497 0 DMOD
C496 497 0 10n
R497 497 498 1k
D497 498 0 DMOD
C497 498 0 10n
R498 498 499 1k
D498 499 0 DMOD
C498 499 0 10n
R499 499 500 1k
D499 500 0 DMOD
C499 500 0 10n
R500 500 501 1k
D500 501 0 DMOD
C500 501 0 10n

.TRAN 5u 2m 0
.END
