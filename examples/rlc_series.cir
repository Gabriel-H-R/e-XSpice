* RLC Series Circuit

V1 1 0 DC 10
R1 1 2 100
L1 2 3 10m IC=0
C1 3 0 1u IC=0

.TRAN 10u 10m 0
.END
