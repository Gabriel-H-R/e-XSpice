* Inversor CMOS com BSIM4 via Berkeley C adapter + pulso na entrada
.MODEL NMOS_BSIM4 NMOS2 (LEVEL=2 VTH0=0.4 KP=100e-6 LAMBDA=0.02 PHI=0.6 GAMMA=0.4 TOX=5e-9 LD=0.1e-6 U0=0.05 VSAT=8e4 UA=1e-9 UB=7.8e-19 UC=-4.9e-11 CGSO=0.5e-9 CGDO=0.5e-9 CGBO=0.0 IS=1e-14 PB=0.8 MJ=0.5 FC=0.5 CBD=1e-12 CBS=1e-12 TNOM=27 TEMP=27 GMIN=1e-12)
.MODEL PMOS_BSIM4 PMOS2 (LEVEL=2 VTH0=-0.4 KP=40e-6 LAMBDA=0.02 PHI=0.6 GAMMA=0.4 TOX=5e-9 LD=0.1e-6 U0=0.02 VSAT=8e4 UA=1e-9 UB=7.8e-19 UC=-4.9e-11 CGSO=0.5e-9 CGDO=0.5e-9 CGBO=0.0 IS=1e-14 PB=0.8 MJ=0.5 FC=0.5 CBD=1e-12 CBS=1e-12 TNOM=27 TEMP=27 GMIN=1e-12)

V1 VDD 0 DC 5.0
V2 VIN 0 PULSE(0 5 0 1n 1n 10n 20n)

M1 VOUT VIN 0 0 NMOS_BSIM4 W=100e-6 L=1e-6 USEBERKELEYKERNEL=1
M2 VOUT VIN VDD VDD PMOS_BSIM4 W=200e-6 L=1e-6 USEBERKELEYKERNEL=1

R1 VOUT 0 1meg

.OP
.TRAN 1n 100n
.PRINT TRAN V(VOUT) V(VIN)
.END
