* Level1 inverter tran
.MODEL NMOS NMOS (LEVEL=1 VTO=0.4 KP=100e-6 LAMBDA=0.02 PHI=0.6 GAMMA=0.4 TOX=5e-9 CGSO=0.5e-9 CGDO=0.5e-9 CBD=1e-12 CBS=1e-12)
.MODEL PMOS PMOS (LEVEL=1 VTO=-0.4 KP=40e-6 LAMBDA=0.02 PHI=0.6 GAMMA=0.4 TOX=5e-9 CGSO=0.5e-9 CGDO=0.5e-9 CBD=1e-12 CBS=1e-12)
V1 VDD 0 DC 5.0
Vin VIN 0 PULSE(0 5 1u 10n 10n 2u 4u)
M1 VOUT VIN 0 0 NMOS W=100e-6 L=1e-6
M2 VOUT VIN VDD VDD PMOS W=200e-6 L=1e-6
R1 VOUT 0 1meg
.TRAN 10n 10u
.PRINT TRAN V(VOUT) V(VIN)
.end
