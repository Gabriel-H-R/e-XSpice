* Level1 inverter
.MODEL NMOS NMOS (LEVEL=1 VTO=0.4 KP=100e-6 LAMBDA=0.02 PHI=0.6 GAMMA=0.4)
.MODEL PMOS PMOS (LEVEL=1 VTO=-0.4 KP=40e-6 LAMBDA=0.02 PHI=0.6 GAMMA=0.4)
V1 VDD 0 DC 5.0
Vin VIN 0 DC 0
M1 VOUT VIN 0 0 NMOS W=100e-6 L=1e-6
M2 VOUT VIN VDD VDD PMOS W=200e-6 L=1e-6
R1 VOUT 0 1meg
.OP
.end
