* .SENS AC through the CLI: RC low-pass.
*
*   V1 in 0 DC 1 AC 1
*   R1 in out 1k
*   C1 out 0 1u
*
* Closed form (H = 1/(1+sRC)):
*   dH/dR = -sC/(1+sRC)^2
*   dH/dC = -sR/(1+sRC)^2
*
* The CSV carries the objective magnitude/phase and the sensitivity
* magnitude/phase of every parameter, at every frequency.
V1 in 0 DC 1 AC 1
R1 in out 1k
C1 out 0 1u
.AC DEC 10 1k 1e6
.SENS AC V(out) R1,C1
.END
